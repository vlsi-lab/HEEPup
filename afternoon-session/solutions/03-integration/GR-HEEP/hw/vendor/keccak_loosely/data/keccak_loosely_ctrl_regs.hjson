{
    name: "keccak_loosely_ctrl",
    clock_primary: "clk_i",
    reset_primary: "rst_ni",
    bus_interfaces: [
    { protocol: "reg_iface", direction: "device" }
    ],
    regwidth: "32",
    registers: [
        { name: "CTRL"
        	  desc: " Trigger the keccak_loosely "
        	  swaccess: "wo",
        	  hwaccess: "hro",
        	  //hwqe: "true",
        	  fields: [
        	      { bits: "0", name: "START",
        		desc: "Make the keccack starts"
        	      }
        	  ]	
        	},
        	{ name: "STATUS"
        	  desc: " Contains status information about the keccak_loosely"
        	  swaccess: "ro",
        	  hwaccess: "hwo",
        	  //hwext : "true",
        	  fields: [
        	      { bits: "0", name: "STATUS",
        		desc: "If set output of keccack is valid"
        	      }
        	  ]	
         }
    ],
}